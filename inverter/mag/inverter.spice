* NGSPICE file created from inverter.ext - technology: sky130A

.subckt sky130_fd_pr__nfet_01v8_QJH2RS B D S G
X0 S G D B sky130_fd_pr__nfet_01v8 ad=1.305 pd=9.58 as=1.305 ps=9.58 w=4.5 l=0.18
C0 S D 0.36348f
C1 D G 0.07494f
C2 S G 0.07494f
C3 S B 0.4663f
C4 D B 0.4663f
.ends

.subckt sky130_fd_pr__pfet_01v8_XNFZ9Q B D S G VSUBS
X0 S G D B sky130_fd_pr__pfet_01v8 ad=0.87 pd=6.58 as=0.87 ps=6.58 w=3 l=0.18
C0 G B 0.15037f
C1 G S 0.05165f
C2 B D 0.18875f
C3 S D 0.24271f
C4 G D 0.05165f
C5 B S 0.18875f
C6 S VSUBS 0.11019f
C7 D VSUBS 0.11019f
C8 B VSUBS 1.75297f
.ends

.subckt inverter out vss in vdd
XXM1 vss vss out in sky130_fd_pr__nfet_01v8_QJH2RS
XXM2 vdd vdd out in vss sky130_fd_pr__pfet_01v8_XNFZ9Q
C0 in out 0.05068f
C1 vdd out 0.10824f
C2 vdd in 0.07772f
C3 out vss 0.53469f
C4 vdd vss 0.30429f
C5 in vss 0.28289f
.ends
