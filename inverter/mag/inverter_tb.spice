** sch_path: /home/disha/Desktop/inverter/xschem/inverter_tb.sch
**.subckt inverter_tb out in
*.opin out
*.opin in
x1 net1 in out 0 inverter
V1 in 0 PWL(0 0 20n 0 900n 1.8)
V2 net1 0 1.8
**** begin user architecture code

.lib /usr/local/share/pdk/sky130A/libs.tech/ngspice/sky130.lib.spice tt

.control
tran 1n 1u
plot V(in) V(out)
.endc

**** end user architecture code
**.ends

#include inverter.spice

* expanding   symbol:  inverter.sym # of pins=4
** sym_path: /home/disha/Desktop/inverter/xschem/inverter.sym
** sch_path: /home/disha/Desktop/inverter/xschem/inverter.sch
.subckt inverter vdd in out vss
*.ipin in
*.iopin vss
*.iopin vdd
*.opin out
XM1 out in vdd net1 sky130_fd_pr__pfet_01v8 L=0.18 W=3 nf=3 ad=0.58 as=0.58 pd=5.16 ps=5.16 nrd=0.0966666666666667
+ nrs=0.0966666666666667 sa=0 sb=0 sd=0 mult=1
XM3 out in vss vss sky130_fd_pr__nfet_01v8 L=0.18 W=4.5 nf=3 ad=0.87 as=0.87 pd=7.16 ps=7.16 nrd=0.0644444444444444
+ nrs=0.0644444444444444 sa=0 sb=0 sd=0 mult=1
.ends

.end
